RFPA Simulation

.include /private/tmp/rfpa_iter_refresh/two_wl30_vin0.118/temp_circuit_params.txt

* GF180MCU-D — global parameter settings (MC switches off for deterministic sim)
.include /Users/tkong/Documents/GitHub/RFPA/CircuitCollector/CircuitCollector/PDK/gf180mcuD/libs.tech/ngspice/design.ngspice

* Load all device models for the chosen process corner.
* Available corners: typical, ff, ss, fs, sf
.lib '/Users/tkong/Documents/GitHub/RFPA/CircuitCollector/CircuitCollector/PDK/gf180mcuD/libs.tech/ngspice/sm141064.ngspice' typical

* RFPA large-signal simulation template.
* Harmonics, Pout, gain, efficiency, and current limits are computed from the
* transient waveform by the RFPA parser. S-parameter stability still requires
* a dedicated two-port small-signal testbench.

VDD vdd 0 3.3
VBIAS vbias 0 0.79137
VIN rfin_src 0 DC 0 AC 0 SIN(0 0.118 250000000.0)
RSRC rfin_src rfin 50.0

RLOAD rfout 0 50.0

xpa 0 vdd rfin rfout vbias two_stage_single_ended

* Small-signal input-driven two-port estimate.
VDD_S11 vdd_s11 0 3.3
VBIAS_S11 vbias_s11 0 0.79137
VIN_S11 s11_src 0 DC 0 AC 1
RS_S11 s11_src s11_in 50.0
RLOAD_S11 s11_out 0 50.0
XS11 0 vdd_s11 s11_in s11_out vbias_s11 two_stage_single_ended

* Small-signal output-driven reverse/output estimate.
VDD_S22 vdd_s22 0 3.3
VBIAS_S22 vbias_s22 0 0.79137
RIN_S22 s22_in 0 50.0
VOUT_S22 s22_src 0 DC 0 AC 1
RS_S22 s22_src s22_out 50.0
XS22 0 vdd_s22 s22_in s22_out vbias_s22 two_stage_single_ended

.control
save all
.options savecurrents
set filetype=ascii
set wr_singlescale
set wr_vecnames

option temp=27

op
let idc_total = -i(VDD)
let pdc_w = idc_total * 3.3
print idc_total pdc_w > two_stage_single_ended_DC.txt

ac dec 50 1000000.0 1000000000.0
wrdata two_stage_single_ended_SPARAM.txt frequency v(s11_in) v(s11_out) v(s22_out) v(s22_in)

tran 1e-10 2e-07
wrdata two_stage_single_ended_WAVEFORM.txt time v(rfout) i(VDD)
meas tran vout_avg AVG v(rfout) from=1.6e-07 to=2e-07
meas tran vout_max MAX v(rfout) from=1.6e-07 to=2e-07
meas tran vout_min MIN v(rfout) from=1.6e-07 to=2e-07
meas tran idd_avg AVG i(VDD) from=1.6e-07 to=2e-07
let vout_ac = v(rfout) - vout_avg
meas tran vout_rms RMS vout_ac from=1.6e-07 to=2e-07
let pdc_w = -idd_avg * 3.3
let pin_w = 0.118 * 0.118 / (8 * 50.0)
let f0_hz = 250000000.0
let pout_w = vout_rms * vout_rms / 50.0
let pout_dbm = 10 * log10(pout_w / 1e-3)
let gain_db = 10 * log10(pout_w / pin_w)
let drain_efficiency = 100 * pout_w / pdc_w
let pae = 100 * (pout_w - pin_w) / pdc_w
let iout_rms = vout_rms / 50.0
let iout_pk_est = (vout_max - vout_min) / (2 * 50.0)
let idc_limit_pass = (abs(idd_avg) le 0.01)
let iout_rms_limit_pass = (iout_rms le 0.01)
let iout_pk_limit_pass = (iout_pk_est le 0.01)
let pdc_limit_pass = (pdc_w le 0.033)
print f0_hz pin_w vout_avg vout_rms vout_max vout_min idd_avg pdc_w pout_w pout_dbm gain_db drain_efficiency pae iout_rms iout_pk_est idc_limit_pass iout_rms_limit_pass iout_pk_limit_pass pdc_limit_pass > two_stage_single_ended_LARGE_SIGNAL.txt

* Harmonics are computed from two_stage_single_ended_WAVEFORM.txt in result_parser.py.

.endc
